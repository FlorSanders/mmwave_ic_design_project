ADE simulation setup
Test Project_single_balanced_mixer_core_tb_1: Project/single_balanced_mixer_tb/schematic, simulator spectre
  Models: /homes/user/stud/fall23/fps2116/Documents/Virtuoso/iplRefKit_v1_0_feb_23_10/refPDK/hspice/reference_models.inc
  Variables: pacmag = 1; flo = 60e9; frf = 0; plo = -15; prf = -40
  Temperature: 27
  Analysis hb: fundfreqs=("(60G)") maxharms=("5") tstab=auto errpreset=moderate
  Analysis dc: (saves the operating point)
  Analysis hbac: start=60.001e9 stop=65e9 lin=10
  Analysis sp: start=55e9 stop=65e9 step=1e9 ports=("/PORT0" "/PORT1" "/PORT3")
  Analysis tran: stop=1n errpreset=moderate
  Output M1 ID = OP("/core/M1" "id")
  Output M1 gm = OP("/core/M1" "gm")
  Output M1 gm/ID = OP("/core/M1" "gmoverid")
  Output M1 Cgg = OP("/core/M1" "cgg")
  Output M1 Cdd = OP("/core/M1" "cdd")
  Output M1 Css = OP("/core/M1" "css")
  Output M2 ID = OP("/core/M2" "id")
  Output M2  gm = OP("/core/M2" "gm")
  Output M2 gm/ID = OP("/core/M2" "gmoverid")
  Output M2 CGG = OP("/core/M2" "cgg")
  Output M2 CDD = OP("/core/M2" "cdd")
  Output M2 CSS = OP("/core/M2" "css")
  Output M3 ID = OP("/buffer1/M3" "id")
  Output M3 gm = OP("/buffer1/M3" "gm")
  Output M3 gm/ID = OP("/buffer1/M3" "gmoverid")
  Output M3 CGG = OP("/buffer1/M3" "cgg")
  Output M3 CDD = OP("/buffer1/M3" "cdd")
  Output M3 CSS = OP("/buffer1/M3" "css")
  Output M4 ID = OP("/buffer1/M4" "id")
  Output M4 gm = OP("/buffer1/M4" "gm")
  Output M4 gm/ID = OP("/buffer1/M4" "gmoverid")
  Output M4 CGG = OP("/buffer1/M4" "cgg")
  Output M4 CDD = OP("/buffer1/M4" "cdd")
  Output M4 CSS = OP("/buffer1/M4" "css")
  Output RF Transient = vtime('tran "/rf") (unticked)
  Output IF Transient = (vtime('tran "/if+") - vtime('tran "/if-")) (unticked)
  Output LO Transient = (vtime('tran "/lo+") - vtime('tran "/lo-")) (unticked)
  Output S11 dB20 = db(spm('sp 1 1))
  Output S22 dB20 = db(spm('sp 2 2))
  Output S33 dB20 = db(spm('sp 3 3))
  Output Z11 reOhm = real(zpm('sp 1 1)) (unticked)
  Output Z22 reOhm = real(zpm('sp 2 2)) (unticked)
  Output Z33 reOhm = real(zpm('sp 3 3)) (unticked)
  Output Z11 imOhm = imag(zpm('sp 1 1)) (unticked)
  Output Z22 imOhm = imag(zpm('sp 2 2)) (unticked)
  Output Z33 imOhm = imag(zpm('sp 3 3)) (unticked)
  Output LO-IF-LEAKAGE = value(db(rms((vh('hb "/if+") - vh('hb "/if-")))) 6e+10)
  Signals: /lo+, /lo-
