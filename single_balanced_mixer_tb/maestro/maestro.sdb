ADE simulation setup
Run mode: Single Run, Sweeps and Corners
Tests:
  Project_single_balanced_mixer_core_tb_1: Project/single_balanced_mixer_tb/schematic, simulator spectre
    Variables: flo = 60e9; frf = 61e9; plo = 5; prf = -40; pacmag = 1
    Outputs: OP("/I0/M2" "gmoverid"); M1 ID; M1 gm; M1 gm/ID; M1 Cgg; M1 Cdd; M1 Css; M2 ID; M2  gm; M2 gm/ID; M2 CGG; M2 CDD; M2 CSS; nil; M3 ID; M3 gm; M3 gm/ID; M3 CGG; M3 CDD; M3 CSS; M4 ID; M4 gm; M4 gm/ID; M4 CGG; M4 CDD; M4 CSS; Output Noise Separation
  Project_single_balanced_mixer_tb_1: Project/single_balanced_mixer_tb/schematic, simulator spectre
    Variables: flo = 60G; frf = 60.1G; pacmag = 1; plo = -5; prf = -30
    Outputs: 1dB Compression Point Plot
