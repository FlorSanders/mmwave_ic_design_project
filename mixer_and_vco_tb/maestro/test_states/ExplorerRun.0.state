ADE simulation setup
Test Project_single_balanced_mixer_tb_1: Project/mixer_and_vco_tb/schematic, simulator spectre
  Models: /homes/user/stud/fall23/fps2116/Documents/Virtuoso/iplRefKit_v1_0_feb_23_10/refPDK/hspice/reference_models.inc
  Variables: frf = 60.1G; pacmag = 1; prf = -70
  Temperature: 27
  Analysis hb: sweep prf start=-70 stop=0 sweepStep=5 fundfreqs=("(60G)" "(60.1G)") maxharms=("5" "10") tstab=5n errpreset=moderate
  Analysis hbac: start=60.1G
  Analysis tran: stop=5n errpreset=moderate noisefmax=1T
  Output 1dB Compression Voltage = compressionVRICurves((v("/if+" ?result "hb_mt_fi") - v("/if-" ?result "hb_mt_fi")) '(-1 1) ?rport 100 ?gcomp 1)
  Output 1dB Compression Gain = compressionVRICurves((v("/if+" ?result "hb_mt_fi") - v("/if-" ?result "hb_mt_fi")) '(-1 1) ?rport 100 ?gcomp 1 ?format "gain")
  Output Voltage Gain = db(((vh('hb "/if+" '((-1 1))) - vh('hb "/if-" '((-1 1)))) / (vh('hb "/rf" '((0 1))) - vh('hb "/gnd" '((0 1))))))
  Signals: /if+, /if-
