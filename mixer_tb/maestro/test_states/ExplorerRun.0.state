ADE simulation setup
Test Project_single_balanced_mixer_tb_1: Project/mixer_tb/schematic, simulator spectre
  Models: /homes/user/stud/fall23/fps2116/Documents/Virtuoso/iplRefKit_v1_0_feb_23_10/refPDK/hspice/reference_models.inc
  Variables: flo = 60G; frf = 60.1G; pacmag = 1; plo = -5; prf = -100
  Temperature: 27
  Analysis hb: sweep prf start=-100 stop=0 sweepStep=10 fundfreqs=("(60G)" "(60.1G)") maxharms=("5" "10") tstab=5n errpreset=moderate
  Analysis hbac: start=60.1G
  Output 1dB Compression Point Plot = compressionVRICurves((v("/if+" ?result "hb_mt_fi") - v("/if-" ?result "hb_mt_fi")) '(-1 1) ?rport 100 ?gcomp 1) (unticked)
  Output 1dB Compression Point Gain = compressionVRICurves((v("/if+" ?result "hb_mt_fi") - v("/if-" ?result "hb_mt_fi")) '(-1 1) ?rport 50 ?gcomp 1 ?format "gain")
  Signals: /if+, /if-
