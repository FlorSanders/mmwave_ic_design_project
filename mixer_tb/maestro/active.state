ADE simulation setup
Test Project_single_balanced_mixer_tb_1: Project/mixer_tb/schematic, simulator spectre
  Models: /homes/user/stud/fall23/fps2116/Documents/Virtuoso/iplRefKit_v1_0_feb_23_10/refPDK/hspice/reference_models.inc
  Variables: flo = 60G; frf = 60.1G; pacmag = 1; plo = -5; prf = -100
  Temperature: 27
  Analysis hb: sweep prf start=-100 stop=0 sweepStep=10 fundfreqs=("(60G)" "(60.1G)") maxharms=("5" "10") tstab=5n errpreset=moderate
  Analysis hbac: start=60.1G
  Output 1dB Compression Point Plot = compressionVRICurves((v("/if+" ?result "hb_mt_fi") - v("/if-" ?result "hb_mt_fi")) '(-1 1) ?rport 100 ?gcomp 1)
  Output 1dB Compression Point Gain = compressionVRICurves((v("/if+" ?result "hb_mt_fi") - v("/if-" ?result "hb_mt_fi")) '(-1 1) ?rport 50 ?gcomp 1 ?format "gain")
  Signals: /if+, /if-
Test Project_single_balanced_mixer_core_tb_1: Project/mixer_tb/schematic, simulator spectre
  Models: /homes/user/stud/fall23/fps2116/Documents/Virtuoso/iplRefKit_v1_0_feb_23_10/refPDK/hspice/reference_models.inc
  Variables: pacmag = 1; flo = 60e9; frf = 0; plo = -5; prf = -50
  Temperature: 27
  Analysis hb: fundfreqs=("(60G)") maxharms=("5") tstab=auto errpreset=moderate
  Analysis hbnoise: start=-5e9 stop=5e9 step=0.1e9 p=/if+ n=/if- oprobe=/PORT3 iprobe=/PORT0 sweeptype=absolute refsideband=("1") noisetype=timeaverage donoise=t
  Analysis sp: start=55G stop=65G dec=10 ports=("/PORT0" "/PORT1" "/PORT3")
  Analysis hbac: start=55e9 stop=65e9 step=1e9
  Analysis tran: stop=5n errpreset=moderate
  Analysis dc: (saves the operating point)
  Output M1 ID = OP("/core/M1" "id")
  Output M1 gm = OP("/core/M1" "gm")
  Output M1 gm/ID = OP("/core/M1" "gmoverid")
  Output M1 Cgg = OP("/core/M1" "cgg")
  Output M1 Cdd = OP("/core/M1" "cdd")
  Output M1 Css = OP("/core/M1" "css")
  Output M2 ID = OP("/core/M2" "id")
  Output M2  gm = OP("/core/M2" "gm")
  Output M2 gm/ID = OP("/core/M2" "gmoverid")
  Output M2 CGG = OP("/core/M2" "cgg")
  Output M2 CDD = OP("/core/M2" "cdd")
  Output M2 CSS = OP("/core/M2" "css")
  Output M3 ID = OP("/buffer1/M3" "id")
  Output M3 gm = OP("/buffer1/M3" "gm")
  Output M3 gm/ID = OP("/buffer1/M3" "gmoverid")
  Output M3 CGG = OP("/buffer1/M3" "cgg")
  Output M3 CDD = OP("/buffer1/M3" "cdd")
  Output M3 CSS = OP("/buffer1/M3" "css")
  Output M4 ID = OP("/buffer1/M4" "id")
  Output M4 gm = OP("/buffer1/M4" "gm")
  Output M4 gm/ID = OP("/buffer1/M4" "gmoverid")
  Output M4 CGG = OP("/buffer1/M4" "cgg")
  Output M4 CDD = OP("/buffer1/M4" "cdd")
  Output M4 CSS = OP("/buffer1/M4" "css")
  Output RF Transient = vtime('tran "/rf")
  Output IF Transient = (vtime('tran "/if+") - vtime('tran "/if-"))
  Output LO Transient = (vtime('tran "/lo+") - vtime('tran "/lo-"))
  Output S11 dB20 = db(spm('sp 1 1))
  Output S22 dB20 = db(spm('sp 2 2))
  Output S33 dB20 = db(spm('sp 3 3))
  Output Z11 reOhm = real(zpm('sp 1 1))
  Output Z22 reOhm = real(zpm('sp 2 2)) (unticked)
  Output Z33 reOhm = real(zpm('sp 3 3))
  Output Z11 imOhm = imag(zpm('sp 1 1))
  Output Z22 imOhm = imag(zpm('sp 2 2)) (unticked)
  Output Z33 imOhm = imag(zpm('sp 3 3))
  Output LO-IF-LEAKAGE = value(db(rms((vh('hb "/if+") - vh('hb "/if-")))) 6e+10)
  Output Conversion Gain = db((vh('hbac "/if+") - vh('hbac "/if-")))
  Output HB Output = db(rms((vh('hb "/if+") - vh('hb "/if-"))))
  Output NF over Frequency = getData("NFdsb" ?result "hbnoise")
  Output Output Noise Separation = db(harmonic(sqrt(getData("out" ?result "hbnoise_xfersrc")) '(-2 -1 0 1 2))) (unticked)
  Output NF = (10 * log10((integ((getData("out" ?result "hbnoise")**2) -5e+09 5e+09) / integ(((getData("out" ?result "hbnoise")**2) / (10**(getData("NFdsb" ?result "hbnoise") / 10))) -5e+09 5e+09))))
  Output v /rfx; tran (V) = vtime('tran "/rfx")
  Signals: /lo+, /lo-
Run mode: Single Run, Sweeps and Corners
Setup values for test Project_single_balanced_mixer_core_tb_1: plo = 5
Setup values for test Project_single_balanced_mixer_tb_1: plo = 5; prf = -30
