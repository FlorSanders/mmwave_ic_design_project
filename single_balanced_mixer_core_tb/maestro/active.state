ADE simulation setup
Test Project_single_balanced_mixer_core_tb_1: Project/single_balanced_mixer_core_tb/schematic, simulator spectre
  Models: /homes/user/stud/fall23/fps2116/Documents/Virtuoso/iplRefKit_v1_0_feb_23_10/refPDK/hspice/reference_models.inc
  Temperature: 27
  Analysis dc: (saves the operating point)
  Output OP("/I0/M1" "id")
  Output OP("/I0/M1" "gm")
  Output OP("/I0/M1" "gmoverid")
  Output OP("/I0/M1" "cgg")
  Output OP("/I0/M1" "cdd")
  Output OP("/I0/M1" "css")
  Output OP("/I0/M2" "id")
  Output OP("/I0/M2" "gm")
  Output OP("/I0/M2" "gmoverid")
  Output OP("/I0/M2" "cgg")
  Output OP("/I0/M2" "cdd")
  Output OP("/I0/M2" "css")
Run mode: Single Run, Sweeps and Corners
