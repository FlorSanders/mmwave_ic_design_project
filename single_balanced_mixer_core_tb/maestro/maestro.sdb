ADE simulation setup
Run mode: Single Run, Sweeps and Corners
Tests:
  Project_single_balanced_mixer_core_tb_1: Project/single_balanced_mixer_core_tb/schematic, simulator spectre
