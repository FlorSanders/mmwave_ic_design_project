ADE simulation setup
Test Project_single_balanced_mixer_core_tb_1: Project/single_balanced_mixer_core_tb_gain/schematic, simulator spectre
  Models: /homes/user/stud/fall23/fps2116/Documents/Virtuoso/iplRefKit_v1_0_feb_23_10/refPDK/hspice/reference_models.inc
  Variables: pacmag = 1; flo = 60e9; frf = 0; plo = -15; prf = -30
  Temperature: 27
  Analysis hbac: start=60.006e9 stop=70e9 step=1e9
  Analysis dc: (saves the operating point)
  Analysis hb: sweep prf start=-70 stop=-50 sweepStep=5 fundfreqs=("(60e9)") maxharms=("5") tstab=1e-9 errpreset=moderate
  Analysis hbnoise: start=1k stop=5G dec=3 p=/if+ n=/if- oprobe=/PORT3 iprobe=/PORT0 sweeptype=relative refsideband=("0") noisetype=timeaverage donoise=t
  Output OP("/I0/M1" "id")
  Output OP("/I0/M1" "gm")
  Output OP("/I0/M1" "gmoverid")
  Output OP("/I0/M1" "cgg")
  Output OP("/I0/M1" "cdd")
  Output OP("/I0/M1" "css")
  Output OP("/I0/M2" "id")
  Output OP("/I0/M2" "gm")
  Output OP("/I0/M2" "cgg")
  Output OP("/I0/M2" "cdd")
  Output OP("/I0/M2" "css")
  Output OP("/I0/M2" "gmoverid")
  Output Output Spectrum = db(rms(vh('hb "/if+")))
  Output Conversion Gain = db(vh('hbac "/if+"))
  Output NFdsb = getData("NFdsb" ?result "hbnoise")
  Output NFdsb Integrated = (10 * log10((integ(((getData("out" ?result "hbnoise")**2) - pv("PORT3" "total" ?result "hbnoise")) 1000 5e+09) / integ((((getData("out" ?result "hbnoise")**2) - pv("PORT3" "total" ?result "hbnoise")) / (10**(getData("NFdsb" ?result "hbnoise") / 10))) 1000 5e+09))))
  Signals: /lo+, /lo-
Run mode: Single Run, Sweeps and Corners
