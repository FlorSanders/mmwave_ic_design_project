ADE simulation setup
Run mode: Single Run, Sweeps and Corners
Tests:
  Project_single_balanced_mixer_core_tb_1: Project/single_balanced_mixer_core_tb_gain/schematic, simulator spectre
    Variables: flo = 60e9; frf = 0; plo = -15; prf = -30; pacmag = 1
    Outputs: OP("/I0/M2" "gmoverid")
