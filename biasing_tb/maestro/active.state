ADE simulation setup
Test Project_biasing_tb_1: Project/biasing_tb/schematic, simulator spectre
  Models: /homes/user/stud/fall23/fps2116/Documents/Virtuoso/iplRefKit_v1_0_feb_23_10/refPDK/hspice/reference_models.inc
  Temperature: 27
  Analysis dc: (saves the operating point)
  Output OP("/I0/M0" "id")
  Output OP("/I0/M0" "gmoverid")
  Output OP("/I0/M0" "vgs")
  Output OP("/I0/M1" "id")
  Output OP("/I0/M1" "gmoverid")
  Output OP("/I0/M1" "vgs")
  Output OP("/I0/M2" "id")
  Output OP("/I0/M2" "gmoverid")
  Output OP("/I0/M2" "vgs")
Run mode: Single Run, Sweeps and Corners
