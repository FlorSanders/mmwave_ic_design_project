ADE simulation setup
Test Project_single_balanced_mixer_core_tb_1: Project/system_tb/schematic, simulator spectre
  Models: /homes/user/stud/fall23/fps2116/Documents/Virtuoso/iplRefKit_v1_0_feb_23_10/refPDK/hspice/reference_models.inc
  Variables: pacmag = 1; frf = 0; prf = -100
  Temperature: 27
  Analysis tran: stop=5n errpreset=moderate noisefmax=1T
  Analysis hbac: start=55e9 stop=65e9 step=1e9
  Analysis dc: (saves the operating point)
  Analysis sp: start=55e9 stop=65e9 step=1e9 ports=("/PORT1" "/PORT2")
  Analysis hbnoise: start=1 stop=5e9 dec=10 p=/if+ n=/if- oprobe=/PORT3 iprobe=/PORT1 sweeptype=absolute refsideband=("1") noisetype=timeaverage donoise=t
  Analysis hb: fundfreqs=("(60G)") maxharms=("5") tstab=5n errpreset=moderate
  Output M1 ID = OP("/core/M1" "id")
  Output M1 gm = OP("/core/M1" "gm")
  Output M1 gm/ID = OP("/core/M1" "gmoverid")
  Output M1 Cgg = OP("/core/M1" "cgg")
  Output M1 Cdd = OP("/core/M1" "cdd")
  Output M1 Css = OP("/core/M1" "css")
  Output M2 ID = OP("/core/M2" "id")
  Output M2  gm = OP("/core/M2" "gm")
  Output M2 gm/ID = OP("/core/M2" "gmoverid")
  Output M2 CGG = OP("/core/M2" "cgg")
  Output M2 CDD = OP("/core/M2" "cdd")
  Output M2 CSS = OP("/core/M2" "css")
  Output M3 ID = OP("/buffer1/M3" "id")
  Output M3 gm = OP("/buffer1/M3" "gm")
  Output M3 gm/ID = OP("/buffer1/M3" "gmoverid")
  Output M3 CGG = OP("/buffer1/M3" "cgg")
  Output M3 CDD = OP("/buffer1/M3" "cdd")
  Output M3 CSS = OP("/buffer1/M3" "css")
  Output M4 ID = OP("/buffer1/M4" "id")
  Output M4 gm = OP("/buffer1/M4" "gm")
  Output M4 gm/ID = OP("/buffer1/M4" "gmoverid")
  Output M4 CGG = OP("/buffer1/M4" "cgg")
  Output M4 CDD = OP("/buffer1/M4" "cdd")
  Output M4 CSS = OP("/buffer1/M4" "css")
  Output RF Transient = vtime('tran "/rf") (unticked)
  Output IF Transient = (vtime('tran "/if+") - vtime('tran "/if-")) (unticked)
  Output LO Transient = (vtime('tran "/lo+") - vtime('tran "/lo-")) (unticked)
  Output S11 dB20 = db(spm('sp 1 1))
  Output S22 dB20 = db(spm('sp 2 2)) (unticked)
  Output Z11 reOhm = real(zpm('sp 1 1))
  Output Z11 imOhm = imag(zpm('sp 1 1))
  Output Z22 imOhm = imag(zpm('sp 2 2)) (unticked)
  Output LO-IF-LEAKAGE = value(db(rms((vh('hb "/if+") - vh('hb "/if-")))) 6e+10)
  Output Conversion Gain = db((vh('hbac "/if+") - vh('hbac "/if-")))
  Output HB Output = db(rms((vh('hb "/if+") - vh('hb "/if-"))))
  Output NF over Frequency = getData("NFdsb" ?result "hbnoise")
  Output Output Noise Separation = db(harmonic(sqrt(getData("out" ?result "hbnoise_xfersrc")) '(-2 -1 0 1 2))) (unticked)
  Output X = (10 * log10((integ((getData("out" ?result "hbnoise")**2) -5e+09 5e+09) / integ(((getData("out" ?result "hbnoise")**2) / (10**(getData("NFdsb" ?result "hbnoise") / 10))) -5e+09 5e+09))))
  Signals: /lo+, /lo-
Test Project_single_balanced_mixer_tb_1: Project/system_tb/schematic, simulator spectre
  Models: /homes/user/stud/fall23/fps2116/Documents/Virtuoso/iplRefKit_v1_0_feb_23_10/refPDK/hspice/reference_models.inc
  Variables: frf = 60.1G; pacmag = 1; prf = -100
  Temperature: 27
  Analysis hb: sweep prf start=-100 stop=0 sweepStep=10 fundfreqs=("(60G)" "(60.1G)") maxharms=("5" "10") tstab=5n errpreset=moderate
  Analysis dc: (saves the operating point)
  Analysis tran: stop=5n errpreset=moderate noisefmax=1T
  Analysis hbac: start=60.1G
  Output 1dB Compression Voltage = compressionVRICurves((v("/if+" ?result "hb_mt_fi") - v("/if-" ?result "hb_mt_fi")) '(-1 1) ?rport 100 ?gcomp 1)
  Output 1dB Compression Gain = compressionVRICurves((v("/if+" ?result "hb_mt_fi") - v("/if-" ?result "hb_mt_fi")) '(-1 1) ?rport 100 ?gcomp 1 ?format "gain")
  Output v /in; tran (V) = vtime('tran "/in")
  Output v /rf; tran (V) = vtime('tran "/rf")
  Output v (/ifp+ /ifp-); tran (V) = (vtime('tran "/ifp+") - vtime('tran "/ifp-"))
  Output v (/if+ /if-); tran (V) = (vtime('tran "/if+") - vtime('tran "/if-"))
  Output v /rf; tstab (V) = v("/rf" ?result "pss_tran") (unticked)
  Output v (/lo+ /lo-); tstab (V) = (v("/lo+" ?result "pss_tran") - v("/lo-" ?result "pss_tran")) (unticked)
  Signals: /if+, /if-
Run mode: Single Run, Sweeps and Corners
Setup values for test Project_single_balanced_mixer_core_tb_1: prf = -70
Setup values for test Project_single_balanced_mixer_tb_1: prf = -60
