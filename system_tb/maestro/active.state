ADE simulation setup
Test Project_single_balanced_mixer_core_tb_1: Project/system_tb/schematic, simulator spectre
  Models: /homes/user/stud/fall23/fps2116/Documents/Virtuoso/iplRefKit_v1_0_feb_23_10/refPDK/hspice/reference_models.inc
  Variables: pacmag = 1; frf = 0; prf = -30
  Temperature: 27
  Analysis hb: fundfreqs=("(60G)") maxharms=("10") tstab=5n errpreset=moderate
  Analysis hbnoise: start=1 stop=5e9 dec=10 p=/if+ n=/if- oprobe=/PORT3 iprobe=/PORT1 sweeptype=absolute refsideband=("1") noisetype=timeaverage donoise=t
  Analysis sp: start=55e9 stop=65e9 step=1e9 ports=("/PORT1" "/PORT2")
  Analysis dc: (saves the operating point)
  Analysis hbac: start=55e9 stop=65e9 step=1e9
  Output M1 ID = OP("/core/M1" "id")
  Output M1 gm = OP("/core/M1" "gm")
  Output M1 gm/ID = OP("/core/M1" "gmoverid")
  Output M1 Cgg = OP("/core/M1" "cgg")
  Output M1 Cdd = OP("/core/M1" "cdd")
  Output M1 Css = OP("/core/M1" "css")
  Output M2 ID = OP("/core/M2" "id")
  Output M2  gm = OP("/core/M2" "gm")
  Output M2 gm/ID = OP("/core/M2" "gmoverid")
  Output M2 CGG = OP("/core/M2" "cgg")
  Output M2 CDD = OP("/core/M2" "cdd")
  Output M2 CSS = OP("/core/M2" "css")
  Output RF Transient = vtime('tran "/rf")
  Output IF Transient = (vtime('tran "/if+") - vtime('tran "/if-"))
  Output LO Transient = (vtime('tran "/lo+") - vtime('tran "/lo-"))
  Output S11 dB20 = db(spm('sp 1 1))
  Output S22 dB20 = db(spm('sp 2 2)) (unticked)
  Output Z11 reOhm = real(zpm('sp 1 1))
  Output Z11 imOhm = imag(zpm('sp 1 1))
  Output Z22 imOhm = imag(zpm('sp 2 2)) (unticked)
  Output LO-IF-LEAKAGE = value(db(rms((vh('hb "/if+") - vh('hb "/if-")))) 6e+10)
  Output Conversion Gain = (db((vh('hbac "/if+") - vh('hbac "/if-"))) - 3)
  Output HB Output = db(rms((vh('hb "/if+") - vh('hb "/if-"))))
  Output NF over Frequency = getData("NFdsb" ?result "hbnoise")
  Output Output Noise Separation = db(harmonic(sqrt(getData("out" ?result "hbnoise_xfersrc")) '(-2 -1 0 1 2))) (unticked)
  Output NF = (10 * log10((integ((getData("out" ?result "hbnoise")**2) -5e+09 5e+09) / integ(((getData("out" ?result "hbnoise")**2) / (10**(getData("NFdsb" ?result "hbnoise") / 10))) -5e+09 5e+09))))
  Signals: /lo+, /lo-
Test Project_single_balanced_mixer_tb_1: Project/system_tb/schematic, simulator spectre
  Models: /homes/user/stud/fall23/fps2116/Documents/Virtuoso/iplRefKit_v1_0_feb_23_10/refPDK/hspice/reference_models.inc
  Variables: frf = 60.1G; pacmag = 1; prf = -70
  Temperature: 27
  Analysis hb: sweep prf start=-70 stop=0 sweepStep=5 fundfreqs=("(60G)" "(60.1G)") maxharms=("5" "10") tstab=5n errpreset=liberal
  Analysis hbac: start=60.1G
  Output 1dB Compression Voltage = compressionVRICurves((v("/if+" ?result "hb_mt_fi") - v("/if-" ?result "hb_mt_fi")) '(-1 1) ?rport 100 ?gcomp 1) (unticked)
  Output 1dB Compression Gain = compressionVRICurves((v("/if+" ?result "hb_mt_fi") - v("/if-" ?result "hb_mt_fi")) '(-1 1) ?rport 100 ?gcomp 1 ?format "gain")
  Output Voltage Gain = (db(((vh('hb "/if+" '((-1 1))) - vh('hb "/if-" '((-1 1)))) / (vh('hb "/rf" '((0 1))) - vh('hb "/gnd" '((0 1)))))))
  Signals: /if+, /if-
Run mode: Single Run, Sweeps and Corners
Setup values for test Project_single_balanced_mixer_tb_1: prf = -60
