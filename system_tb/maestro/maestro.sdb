ADE simulation setup
Run mode: Single Run, Sweeps and Corners
Tests:
  Project_single_balanced_mixer_core_tb_1: Project/system_tb/schematic, simulator spectre
    Variables: frf = 0; prf = -30; pacmag = 1
    Outputs: OP("/I0/M2" "gmoverid"); M1 ID; M1 gm; M1 gm/ID; M1 Cgg; M1 Cdd; M1 Css; M2 ID; M2  gm; M2 gm/ID; M2 CGG; M2 CDD; M2 CSS; nil; Output Noise Separation; Conversion Gain
  Project_single_balanced_mixer_tb_1: Project/system_tb/schematic, simulator spectre
    Variables: frf = 60.1G; pacmag = 1; prf = -70
    Outputs: 1dB Compression Voltage; Voltage Gain
