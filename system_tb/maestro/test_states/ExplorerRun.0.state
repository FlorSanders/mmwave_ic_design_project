ADE simulation setup
Test Project_single_balanced_mixer_tb_1: Project/system_tb/schematic, simulator spectre
  Models: /homes/user/stud/fall23/fps2116/Documents/Virtuoso/iplRefKit_v1_0_feb_23_10/refPDK/hspice/reference_models.inc
  Variables: frf = 60.1G; pacmag = 1; prf = -100
  Temperature: 27
  Analysis hb: sweep prf start=-100 stop=0 sweepStep=10 fundfreqs=("(60G)" "(60.1G)") maxharms=("5" "10") tstab=5n errpreset=moderate
  Analysis dc: (saves the operating point)
  Analysis tran: stop=5n errpreset=moderate noisefmax=1T
  Analysis hbac: start=60.1G
  Output 1dB Compression Voltage = compressionVRICurves((v("/if+" ?result "hb_mt_fi") - v("/if-" ?result "hb_mt_fi")) '(-1 1) ?rport 100 ?gcomp 1)
  Output 1dB Compression Gain = compressionVRICurves((v("/if+" ?result "hb_mt_fi") - v("/if-" ?result "hb_mt_fi")) '(-1 1) ?rport 100 ?gcomp 1 ?format "gain")
  Output v /in; tran (V) = vtime('tran "/in")
  Output v /rf; tran (V) = vtime('tran "/rf")
  Output v (/ifp+ /ifp-); tran (V) = (vtime('tran "/ifp+") - vtime('tran "/ifp-"))
  Output v (/if+ /if-); tran (V) = (vtime('tran "/if+") - vtime('tran "/if-"))
  Output v /rf; tstab (V) = v("/rf" ?result "pss_tran") (unticked)
  Output v (/lo+ /lo-); tstab (V) = (v("/lo+" ?result "pss_tran") - v("/lo-" ?result "pss_tran")) (unticked)
  Signals: /if+, /if-
