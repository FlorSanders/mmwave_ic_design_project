ADE simulation setup
Test Project_single_balanced_mixer_core_tb_1: Project/single_balanced_mixer_core_tb_linearity/schematic, simulator spectre
  Models: /homes/user/stud/fall23/fps2116/Documents/Virtuoso/iplRefKit_v1_0_feb_23_10/refPDK/hspice/reference_models.inc
  Variables: flo = 60e9; frf = 60e9; plo = -15; prf = -70; pacmagdb = prf
  Temperature: 27
  Analysis qpac: start=60.01G sweeptype=absolute
  Analysis qpss: sweep prf start=-100 stop=-70 sweepStep=10 engine=Shooting funds=("flo" "frf") maxharms=("10" "5")
  Analysis dc: (saves the operating point)
  Output ipnCurves = ipnVRICurves((v("/net2" ?result "qpac") - v("/gnd" ?result "qpac")) '(-1 2) '(-1 0) ?rport resultParam("Error:r" ?result "qpac") ?epoint -80)
  Output Input Referred IP3 Point = ipnVRI((v("/net2" ?result "qpac") - v("/gnd" ?result "qpac")) '(1 -2) '(-1 2) ?rport resultParam("Error:r" ?result "qpac") ?epoint -80)
  Output 1st Order freq = "cadar(setof(x harmonicFreqList(?result \"qpac\") equal(car(x) '(-1 0))))" (unticked)
  Signals: /net2, /gnd
Run mode: Single Run, Sweeps and Corners
