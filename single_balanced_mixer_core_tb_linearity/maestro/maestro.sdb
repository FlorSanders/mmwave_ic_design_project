ADE simulation setup
Run mode: Single Run, Sweeps and Corners
Tests:
  Project_single_balanced_mixer_core_tb_1: Project/single_balanced_mixer_core_tb_linearity/schematic, simulator spectre
    Variables: flo = 60e9; frf = 60e9; plo = -15; prf = -70; pacmagdb = prf
    Outputs: ipnCurves; Input Referred IP3 Point
