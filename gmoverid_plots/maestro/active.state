ADE simulation setup
Test DAMSIC_2023_gmoverid_plots_1: Project/gmoverid_plots/schematic, simulator spectre
  Models: /homes/user/stud/fall23/fps2116/Documents/Virtuoso/iplRefKit_v1_0_feb_23_10/refPDK/hspice/reference_models.inc
  Variables: Ln = 100n; Wn = 300n; Lp = 100n; Wp = 770n; VSBp = 0; VSBn = 0; VGSn = 500m; VGSp = -500m; VDSn = 500m; VDSp = -500m
  Temperature: 27
  Operating points saved: /NM0 (gm gds gmoverid cgg vth); /PM0 (gm gds gmoverid cgg vth)
  Analysis dc: sweep VGSp start=-1 stop=0 step=10m (saves the operating point)
  Output Vth,n = OS("/NM0" "vth") (unticked)
  Output |Vth,p| = abs(OS("/PM0" "vth"))
  Output IDn = IS("/NM0/D") (unticked)
  Output |IDp| = abs(IS("/PM0/D"))
  Output gm,n = OS("/NM0" "gm") (unticked)
  Output gm,p = OS("/PM0" "gm")
  Output 1/gds,n = (1 / OS("/NM0" "gds")) (unticked)
  Output 1/gds,p = (1 / OS("/PM0" "gds"))
  Output gm/ID,n = OS("/NM0" "gmoverid") (unticked)
  Output gm/ID,p = OS("/PM0" "gmoverid")
  Output fT,n = (OS("/NM0" "gm") / (2 * pi * OS("/NM0" "cgg"))) (unticked)
  Output fT,p = (OS("/PM0" "gm") / (2 * pi * OS("/PM0" "cgg")))
  Output (Aintr,n)dB = dB20((OS("/NM0" "gm") / OS("/NM0" "gds"))) (unticked)
  Output (Aintr,p)dB = dB20((OS("/PM0" "gm") / OS("/PM0" "gds")))
  Output fT,n*Aintr,n = ((OS("/NM0" "gm") / (2 * pi * OS("/NM0" "cgg"))) * (OS("/NM0" "gm") / OS("/NM0" "gds"))) (unticked)
  Output fT,p*Aintr,p = ((OS("/PM0" "gm") / (2 * pi * OS("/PM0" "cgg"))) * (OS("/PM0" "gm") / OS("/PM0" "gds")))
  Output gm,n vs gm/ID,n = waveVsWave(?x OS("/NM0" "gmoverid") ?y OS("/NM0" "gm")) (unticked)
  Output gm,p vs gm/ID,p = waveVsWave(?x OS("/PM0" "gmoverid") ?y OS("/PM0" "gm")) (unticked)
  Output fT,n vs gm/ID,n = waveVsWave(?x OS("/NM0" "gmoverid") ?y (OS("/NM0" "gm") / (2 * pi * OS("/NM0" "cgg")))) (unticked)
  Output fT,p vs gm/ID,p = waveVsWave(?x OS("/PM0" "gmoverid") ?y (OS("/PM0" "gm") / (2 * pi * OS("/PM0" "cgg")))) (unticked)
  Output Aintr,n vs gm/ID,n = waveVsWave(?x OS("/NM0" "gmoverid") ?y dB20((OS("/NM0" "gm") / OS("/NM0" "gds")))) (unticked)
  Output Aintr,p vs gm/ID,p = waveVsWave(?x OS("/PM0" "gmoverid") ?y dB20((OS("/PM0" "gm") / OS("/PM0" "gds")))) (unticked)
  Output fT,n*Aintr,n vs gm/ID,n = waveVsWave(?x OS("/NM0" "gmoverid") ?y ((OS("/NM0" "gm") / (2 * pi * OS("/NM0" "cgg"))) * (OS("/NM0" "gm") / OS("/NM0" "gds")))) (unticked)
  Output fT,p*Aintr,p vs gm/ID,p = waveVsWave(?x OS("/PM0" "gmoverid") ?y ((OS("/PM0" "gm") / (2 * pi * OS("/PM0" "cgg"))) * (OS("/PM0" "gm") / OS("/PM0" "gds")))) (unticked)
  Output ID,n/W vs gm/ID,n = waveVsWave(?x OS("/NM0" "gmoverid") ?y (IS("/NM0/D") / VAR("Wn"))) (unticked)
  Output |ID,p|/W vs gm/ID,p = waveVsWave(?x OS("/PM0" "gmoverid") ?y (abs(IS("/PM0/D")) / VAR("Wp")))
  Output 1/gds,n vs gm/ID,n = waveVsWave(?x OS("/NM0" "gmoverid") ?y (1 / OS("/NM0" "gds"))) (unticked)
  Output 1/gds,p vs gm/ID,p = waveVsWave(?x OS("/PM0" "gmoverid") ?y (1 / OS("/PM0" "gds"))) (unticked)
Run mode: Single Run, Sweeps and Corners
Global variables:
  Ln = 45n
Setup values for test DAMSIC_2023_gmoverid_plots_1: Wn = 13.5u; Lp = 500n; Wp = 5.5u; VDSn = 400m; VDSp = -400m
