ADE simulation setup
Test mmWaveICDesignProject_baseband_amplifier_tb_1: mmWaveICDesignProject/baseband_amplifier_tb/schematic, simulator spectre
  Models: /homes/user/stud/fall23/pf2459/Documents/mmWaveICDesign/Project/iplRefKit_v1_0_feb_23_10/refPDK/hspice/reference_models.inc
  Variables: pin = -10
  Temperature: 27
  Analysis pss: sweep pin start=-50 stop=5 sweepStep=5 engine=Harmonic Balance fund=1G harms=3 errpreset=conservative
  Analysis tran: stop=5n
  Analysis dc: (saves the operating point)
  Analysis stb: start=1 stop=10G probe=/I7 stbProbeMode=differential
  Analysis sp: start=1 stop=10G dec=20 ports=("/PORT0" "/PORT1")
  Output OP("/I0/M0" "region") (unticked)
  Output OP("/I0/M1" "region")
  Output OP("/I0/M2" "region")
  Output OP("/I0/M3" "region")
  Output OP("/I0/M4" "region")
  Output OP("/I0/M5" "region")
  Output OP("/I0/M6" "region")
  Output OP("/I0/M7" "region")
  Output OP("/I0/M8" "region")
  Output OP("/I0/M9" "region")
  Output OP("/I0/M10" "region")
  Output OP("/I0/M11" "region")
  Output OP("/I0/M12" "region")
  Output OP("/I0/M13" "region")
  Output OP("/I0/M14" "region")
  Output value(dB20(VF("/VoutDM")) 1)
  Output bandwidth(VF("/VoutDM") 3 "low")
  Output dB20(VF("/VoutDM"))
  Output phaseDeg(VF("/VoutDM"))
  Output Loop Gain dB20 = db(mag(getData("loopGain" ?result "stb")))
  Output Loop Gain Phase = phaseDegUnwrapped(getData("loopGain" ?result "stb"))
  Output IDC("/V0/MINUS")
  Output S21 dB20 = db(spm('sp 2 1))
  Output OP("/I9/M0" "region")
  Output OP("/I9/M1" "region")
  Output OP("/I9/M2" "region")
  Output OP("/I9/M3" "region")
  Output OP("/I9/M4" "region")
  Output OP("/I9/M5" "region")
  Output OP("/I9/M6" "region")
  Output OP("/I9/M7" "region")
  Output OP("/I9/M8" "region")
  Output OP("/I9/M9" "region")
  Output OP("/I9/M10" "region")
  Output OP("/I9/M11" "region")
  Output OP("/I9/M12" "region")
  Output OP("/I9/M13" "region")
  Output OP("/I9/M14" "region")
  Output compressionCurves = compressionVRICurves((v("/net11" ?result "pss_fd") - v("/net5" ?result "pss_fd")) '1 ?rport resultParam("PORT1:r" ?result "pss_fd") ?gcomp 1 ?format "gain")
  Output Input Referred 1dB Compression Point = compressionVRI((v("/net11" ?result "pss_fd") - v("/net5" ?result "pss_fd")) '1 ?rport resultParam("PORT1:r" ?result "pss_fd") ?gcomp 1 ?format "gain")
  Output 1st Order freq = "cadar(setof(x harmonicFreqList(?result \"pss_fd\") equal(car(x) '1)))"
  Signals: /VinDM, /VinCM, /VoutDM, /VoutCM, /I0/GND (terminal), /V0/MINUS (terminal)
Run mode: Single Run, Sweeps and Corners
Specs:
  mmWaveICDesignProject_baseband_amplifier_tb_1 / OP("/I0/M0" "region"): target 2, tolerance 1%
  mmWaveICDesignProject_baseband_amplifier_tb_1 / OP("/I0/M1" "region"): target 2, tolerance 1%
  mmWaveICDesignProject_baseband_amplifier_tb_1 / OP("/I0/M2" "region"): target 2, tolerance 1%
  mmWaveICDesignProject_baseband_amplifier_tb_1 / OP("/I0/M3" "region"): target 2, tolerance 1%
  mmWaveICDesignProject_baseband_amplifier_tb_1 / OP("/I0/M4" "region"): target 2, tolerance 1%
  mmWaveICDesignProject_baseband_amplifier_tb_1 / OP("/I0/M5" "region"): target 2, tolerance 1%
  mmWaveICDesignProject_baseband_amplifier_tb_1 / OP("/I0/M6" "region"): target 2, tolerance 1%
  mmWaveICDesignProject_baseband_amplifier_tb_1 / OP("/I0/M7" "region"): target 2, tolerance 1%
  mmWaveICDesignProject_baseband_amplifier_tb_1 / OP("/I0/M8" "region"): target 2, tolerance 1%
  mmWaveICDesignProject_baseband_amplifier_tb_1 / OP("/I0/M9" "region"): target 2, tolerance 1%
  mmWaveICDesignProject_baseband_amplifier_tb_1 / OP("/I0/M10" "region"): target 2, tolerance 1%
  mmWaveICDesignProject_baseband_amplifier_tb_1 / OP("/I0/M11" "region"): target 2, tolerance 1%
  mmWaveICDesignProject_baseband_amplifier_tb_1 / OP("/I0/M12" "region"): target 2, tolerance 1%
  mmWaveICDesignProject_baseband_amplifier_tb_1 / OP("/I0/M13" "region"): target 2, tolerance 1%
  mmWaveICDesignProject_baseband_amplifier_tb_1 / OP("/I0/M14" "region"): target 2, tolerance 1%
  mmWaveICDesignProject_baseband_amplifier_tb_1 / bandwidth(VF("/VoutDM") 3 "low"): > 2G
  mmWaveICDesignProject_baseband_amplifier_tb_1 / value(dB20(VF("/VoutDM")) 1): > 25
  mmWaveICDesignProject_baseband_amplifier_tb_1 / OP("/I9/M1" "region"): target 2, tolerance 1%
  mmWaveICDesignProject_baseband_amplifier_tb_1 / OP("/I9/M2" "region"): target 2, tolerance 1%
  mmWaveICDesignProject_baseband_amplifier_tb_1 / OP("/I9/M3" "region"): target 2, tolerance 1%
  mmWaveICDesignProject_baseband_amplifier_tb_1 / OP("/I9/M4" "region"): target 2, tolerance 1%
  mmWaveICDesignProject_baseband_amplifier_tb_1 / OP("/I9/M5" "region"): target 2, tolerance 1%
  mmWaveICDesignProject_baseband_amplifier_tb_1 / OP("/I9/M6" "region"): target 2, tolerance 1%
  mmWaveICDesignProject_baseband_amplifier_tb_1 / OP("/I9/M7" "region"): target 2, tolerance 1%
  mmWaveICDesignProject_baseband_amplifier_tb_1 / OP("/I9/M8" "region"): target 2, tolerance 1%
  mmWaveICDesignProject_baseband_amplifier_tb_1 / OP("/I9/M9" "region"): target 2, tolerance 1%
  mmWaveICDesignProject_baseband_amplifier_tb_1 / OP("/I9/M10" "region"): target 2, tolerance 1%
  mmWaveICDesignProject_baseband_amplifier_tb_1 / OP("/I9/M11" "region"): target 2, tolerance 1%
  mmWaveICDesignProject_baseband_amplifier_tb_1 / OP("/I9/M12" "region"): target 2, tolerance 1%
  mmWaveICDesignProject_baseband_amplifier_tb_1 / OP("/I9/M13" "region"): target 2, tolerance 1%
  mmWaveICDesignProject_baseband_amplifier_tb_1 / OP("/I9/M14" "region"): target 2, tolerance 1%
