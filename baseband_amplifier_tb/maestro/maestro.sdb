ADE simulation setup
Run mode: Single Run, Sweeps and Corners
Tests:
  mmWaveICDesignProject_baseband_amplifier_tb_1: mmWaveICDesignProject/baseband_amplifier_tb/schematic, simulator spectre
    Variables: pin = -10
    Outputs: /VinDM; /VinCM; /VoutCM; IDC("/I0/GND"); IDC("/V0"); IDC("/V0/MINUS")
Specs:
  mmWaveICDesignProject_baseband_amplifier_tb_1 / OP("/I0/M0" "region"): target 2, tolerance 1%
  mmWaveICDesignProject_baseband_amplifier_tb_1 / OP("/I0/M1" "region"): target 2, tolerance 1%
  mmWaveICDesignProject_baseband_amplifier_tb_1 / OP("/I0/M2" "region"): target 2, tolerance 1%
  mmWaveICDesignProject_baseband_amplifier_tb_1 / OP("/I0/M3" "region"): target 2, tolerance 1%
  mmWaveICDesignProject_baseband_amplifier_tb_1 / OP("/I0/M4" "region"): target 2, tolerance 1%
  mmWaveICDesignProject_baseband_amplifier_tb_1 / OP("/I0/M5" "region"): target 2, tolerance 1%
  mmWaveICDesignProject_baseband_amplifier_tb_1 / OP("/I0/M6" "region"): target 2, tolerance 1%
  mmWaveICDesignProject_baseband_amplifier_tb_1 / OP("/I0/M7" "region"): target 2, tolerance 1%
  mmWaveICDesignProject_baseband_amplifier_tb_1 / OP("/I0/M8" "region"): target 2, tolerance 1%
  mmWaveICDesignProject_baseband_amplifier_tb_1 / OP("/I0/M9" "region"): target 2, tolerance 1%
  mmWaveICDesignProject_baseband_amplifier_tb_1 / OP("/I0/M10" "region"): target 2, tolerance 1%
  mmWaveICDesignProject_baseband_amplifier_tb_1 / OP("/I0/M11" "region"): target 2, tolerance 1%
  mmWaveICDesignProject_baseband_amplifier_tb_1 / OP("/I0/M12" "region"): target 2, tolerance 1%
  mmWaveICDesignProject_baseband_amplifier_tb_1 / OP("/I0/M13" "region"): target 2, tolerance 1%
  mmWaveICDesignProject_baseband_amplifier_tb_1 / OP("/I0/M14" "region"): target 2, tolerance 1%
  mmWaveICDesignProject_baseband_amplifier_tb_1 / bandwidth(VF("/VoutDM") 3 "low"): > 2G
  mmWaveICDesignProject_baseband_amplifier_tb_1 / value(dB20(VF("/VoutDM")) 1): > 25
  mmWaveICDesignProject_baseband_amplifier_tb_1 / OP("/I9/M1" "region"): target 2, tolerance 1%
  mmWaveICDesignProject_baseband_amplifier_tb_1 / OP("/I9/M2" "region"): target 2, tolerance 1%
  mmWaveICDesignProject_baseband_amplifier_tb_1 / OP("/I9/M3" "region"): target 2, tolerance 1%
  mmWaveICDesignProject_baseband_amplifier_tb_1 / OP("/I9/M4" "region"): target 2, tolerance 1%
  mmWaveICDesignProject_baseband_amplifier_tb_1 / OP("/I9/M5" "region"): target 2, tolerance 1%
  mmWaveICDesignProject_baseband_amplifier_tb_1 / OP("/I9/M6" "region"): target 2, tolerance 1%
  mmWaveICDesignProject_baseband_amplifier_tb_1 / OP("/I9/M7" "region"): target 2, tolerance 1%
  mmWaveICDesignProject_baseband_amplifier_tb_1 / OP("/I9/M8" "region"): target 2, tolerance 1%
  mmWaveICDesignProject_baseband_amplifier_tb_1 / OP("/I9/M9" "region"): target 2, tolerance 1%
  mmWaveICDesignProject_baseband_amplifier_tb_1 / OP("/I9/M10" "region"): target 2, tolerance 1%
  mmWaveICDesignProject_baseband_amplifier_tb_1 / OP("/I9/M11" "region"): target 2, tolerance 1%
  mmWaveICDesignProject_baseband_amplifier_tb_1 / OP("/I9/M12" "region"): target 2, tolerance 1%
  mmWaveICDesignProject_baseband_amplifier_tb_1 / OP("/I9/M13" "region"): target 2, tolerance 1%
  mmWaveICDesignProject_baseband_amplifier_tb_1 / OP("/I9/M14" "region"): target 2, tolerance 1%
