ADE simulation setup
Run mode: Single Run, Sweeps and Corners
Tests:
  mmWaveICDesignProject_transistor_characterization_1: mmWaveICDesignProject/transistor_characterization/schematic, simulator spectre
    Variables: Ln = 100n; Wn = 1u; Lp = 100n; Wp = 1u; VGSn = 1; VDSn = 1; VSp = 1; VSDp = 1; VSGp = 1
  mmWaveICDesignProject_transistor_characterization_2: mmWaveICDesignProject/transistor_characterization/schematic, simulator spectre
    Variables: Ln = 100n; Wn = 1u; Lp = 100n; Wp = 1u; VGSn = 1; VDSn = 1; VSp = 1; VSGp = 1; VSDp = 1
    Outputs: Gmax dB10
