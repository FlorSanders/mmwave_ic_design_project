ADE simulation setup
Test mmWaveICDesignProject_transistor_characterization_1: mmWaveICDesignProject/transistor_characterization/schematic, simulator spectre
  Models: /homes/user/stud/fall23/pf2459/Documents/mmWaveICDesign/Project/iplRefKit_v1_0_feb_23_10/refPDK/hspice/reference_models.inc
  Variables: Ln = 100n; Wn = 1u; Lp = 100n; Wp = 1u; VGSn = 1; VDSn = 1; VSp = 1; VSDp = 1; VSGp = 1
  Temperature: 27
  Analysis sp: start=1G stop=1T dec=100 ports=("/PORT0" "/PORT1")
  Output Gmax dB10 = db10(gmax(sp(1 1 ?result "sp") sp(1 2 ?result "sp") sp(2 1 ?result "sp") sp(2 2 ?result "sp")))
Test mmWaveICDesignProject_transistor_characterization_2: mmWaveICDesignProject/transistor_characterization/schematic, simulator spectre
  Models: /homes/user/stud/fall23/pf2459/Documents/mmWaveICDesign/Project/iplRefKit_v1_0_feb_23_10/refPDK/hspice/reference_models.inc
  Variables: Ln = 100n; Lp = 100n; VDSn = 1; VGSn = 1; VSDp = 1; VSGp = 1; VSp = 1; Wn = 1u; Wp = 1u
  Temperature: 27
  Analysis sp: start=1G stop=1T dec=100 ports=("/PORT2" "/PORT3")
  Output Gmax dB10 = db10(gmax(sp(1 1 ?result "sp") sp(1 2 ?result "sp") sp(2 1 ?result "sp") sp(2 2 ?result "sp")))
Run mode: Single Run, Sweeps and Corners
Disabled tests: mmWaveICDesignProject_transistor_characterization_1, mmWaveICDesignProject_transistor_characterization_2
